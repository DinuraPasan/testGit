[IBIS Ver]   4.2
[File Name]  stm32f2_lqfp144.ibs
[File Rev]   1.0
[Date]   31-Aug-2011
[Source]   STMicroelectronics NV
[Notes]   The I/O models have been made by simulation and qualified
   with recomandation of QualityIBIS flow.
   Some Models, library and pin names may be modified.
   Details of modified names can be found below.
ORIGINAL NAME   ::  MODIFIED NAME   :: COMMENTS(if any)
IO8USB_LSFS_OTG_FT  ::  IO8USB_LSFS_OTG_FT_USB   :: Model in USB mode.
IO8USB_LSFS_OTG_FT  ::  IO8USB_LSFS_OTG_FT_NON_USB_DNV33  :: Model in other than USB mode & pad pin = DNV33
IO8USB_LSFS_OTG_FT  ::  IO8USB_LSFS_OTG_FT_NON_USB_DPV33  :: Model in other than USB mode & pad pin = DPV33
[Disclaimer] These IBIS models are the proprietary information of
             STMicroelectronics and are disclosed to users solely for
             modeling and simulation purposes. No further license is
             implied. All warranties express, implied, or statutory,
             including any implied warranty of fitness for a particular
             purpose or implied warranty against infringement, are
             hereby disclaimed. STMicroelectronics reserves the right
             to change the IBIS models at any time and without notice.
[Copyright]  (c) STMicroelectronics
   All rights reserved. Reproduction in whole or part is prohibited
   without the written consent of the copyright holder.
[Component]  STM32F2_LQFP144
[Manufacturer] STMicroelectronics NV
[Package]
| variable   typ   min   max
R_pkg   0.000mOhm   0.000mOhm   0.000mOhm
L_pkg   0.000nH   0.000nH   0.000nH
C_pkg   0.000pF   0.000pF   0.000pF
[Pin]   signal_name   model_name
1 PE2 IO8PROG2M25M50M100M_ARSUDQ_FT
2 PE3 IO8PROG2M25M50M100M_ARSUDQ_FT
3 PE4 IO8PROG2M25M50M100M_ARSUDQ_FT
4 PE5 IO8PROG2M25M50M100M_ARSUDQ_FT
5 PE6 IO8PROG2M25M50M100M_ARSUDQ_FT
|6 VBAT VDD33IOSWCO_MOSSWI_FT
|- PI8 IO8PROG2M25M50M100M_ARSUDQ_FT_V33
7 PC13 IO8PROG2M25M50M100M_ARWSUDQ_FT_V33
8 PC14 IO8PROG2M25M50M100M_ARWSUDQ_FT
9 PC15 IO8PROG2M25M50M100M_ARSUDQ_FT
|- PI9  IO8PROG2M25M50M100M_ARSUDQ_FT
|- PI10 IO8PROG2M25M50M100M_ARSUDQ_FT
|- PI11 IO8PROG2M25M50M100M_ARSUDQ_FT
|- VSS_13 VSSIOCO
|- VDD_13 VDD33IOCO
10 PF0 IO8PROG2M25M50M100M_ARSUDQ_FT
11 PF1 IO8PROG2M25M50M100M_ARSUDQ_FT
12 PF2 IO8PROG2M25M50M100M_ARSUDQ_FT
13 PF3 IO8PROG2M25M50M100M_ARSUDQ_FT
14 PF4 IO8PROG2M25M50M100M_ARSUDQ_FT
15 PF5 IO8PROG2M25M50M100M_ARSUDQ_FT
|16 VSS_5 VSSIOCO
|17 VDD_5 VDD33IOCO
18 PF6 IO8PROG2M25M50M100M_ARSUDQ_FT
19 PF7 IO8PROG2M25M50M100M_ARSUDQ_FT
20 PF8 IO8PROG2M25M50M100M_ARSUDQ_FT
21 PF9  IO8PROG2M25M50M100M_AR3WSUDQ_FT
22 PF10 IO8PROG2M25M50M100M_ARSUDQ_FT
23 PH0 IO8PROG2M25M50M100M_ARSUDQ_FT
24 PH1 IO8PROG2M25M50M100M_ARSUDQ_FT
|25 NRST RESET
26 PC0 IO8PROG2M25M50M100M_AR3WSUDQ_FT
27 PC1 IO8PROG2M25M50M100M_AR3WSUDQ_FT
28 PC2 IO8PROG2M25M50M100M_AR3WSUDQ_FT
29 PC3 IO8PROG2M25M50M100M_AR3WSUDQ_FT
|30 VDD_12 VDD33IOCO_VSSIOCO_MOSSWI_FT
|31 VSSA VSSCO
|32 VREF+ VDD33CO
|33 VDDA VDD33CO
34 PA0 IO8PROG2M25M50M100M_AR3WSUDQ_FT_V33
35 PA1 IO8PROG2M25M50M100M_AR3WSUDQ_FT
36 PA2 IO8PROG2M25M50M100M_AR3WSUDQ_FT
|- PH2 IO8PROG2M25M50M100M_AR3WSUDQ_FT
|- PH3 IO8PROG2M25M50M100M_AR3WSUDQ_FT
|- PH4 IO8PROG2M25M50M100M_AR3WSUDQ_FT
|- PH5 IO8PROG2M25M50M100M_AR3WSUDQ_FT
37 PA3 IO8PROG2M25M50M100M_AR3WSUDQ_FT
|38 VSS_4 VSSIOCO
|39 VDD_4 VDD33IOCO
40 PA4 IO8PROG2M25M50M100M_AR3WSUDQ_FT
41 PA5 IO8PROG2M25M50M100M_AR3WSUDQ_FT
42 PA6 IO8PROG2M25M50M100M_AR3WSUDQ_FT
43 PA7 IO8PROG2M25M50M100M_AR3WSUDQ_FT
44 PC4 IO8PROG2M25M50M100M_AR3WSUDQ_FT
45 PC5 IO8PROG2M25M50M100M_AR3WSUDQ_FT
46 PB0 IO8PROG2M25M50M100M_AR3WSUDQ_FT
47 PB1 IO8PROG2M25M50M100M_AR3WSUDQ_FT
48 PB2 IO8PROG2M25M50M100M_AR3WSUDQ_FT
49 PF11 IO8PROG2M25M50M100M_ARSUDQ_FT
50 PF12 IO8PROG2M25M50M100M_ARSUDQ_FT
|51 VSS_6 VSSIOCO
|52 VDD_6 VDD33IOCO
53 PF13 IO8PROG2M25M50M100M_ARSUDQ_FT
54 PF14 IO8PROG2M25M50M100M_ARSUDQ_FT
55 PF15 IO8PROG2M25M50M100M_ARSUDQ_FT
56 PG0 IO8PROG2M25M50M100M_ARSUDQ_FT
57 PG1 IO8PROG2M25M50M100M_ARSUDQ_FT
58 PE7 IO8PROG2M25M50M100M_ARSUDQ_FT
59 PE8 IO8PROG2M25M50M100M_ARSUDQ_FT
60 PE9 IO8PROG2M25M50M100M_ARSUDQ_FT
|61 VSS_7 VSSIOCO
|62 VDD_7 VDD33IOCO
63 PE10 IO8PROG2M25M50M100M_ARSUDQ_FT
64 PE11 IO8PROG2M25M50M100M_ARSUDQ_FT
65 PE12 IO8PROG2M25M50M100M_ARSUDQ_FT
66 PE13 IO8PROG2M25M50M100M_ARSUDQ_FT
67 PE14 IO8PROG2M25M50M100M_ARSUDQ_FT
68 PE15 IO8PROG2M25M50M100M_ARSUDQ_FT
69 PB10 IO8PROG2M25M50M100M_ARSUDQ_I2CIN_FT
70 PB11 IO8PROG2M25M50M100M_ARSUDQ_I2CIN_FT
|71 VCAP_1
|72 VDD_1 VDD33IOCO
|- PH6 IO8PROG2M25M50M100M_ARSUDQ_FT
|- PH7 IO8PROG2M25M50M100M_ARSUDQ_FT
|- PH8 IO8PROG2M25M50M100M_ARSUDQ_FT
|- PH9 IO8PROG2M25M50M100M_ARSUDQ_FT
|- PH10 IO8PROG2M25M50M100M_ARSUDQ_FT
|- PH11 IO8PROG2M25M50M100M_ARSUDQ_FT
|- PH12 IO8PROG2M25M50M100M_ARSUDQ_FT
|- VSS_14 VSSIOCO
|- VDD_14 VDD33IOCO
73 PB12 IO8USB_ID_OTG_FT
74 PB13 IO8USB_VBUS_OTG_FT
75 PB14 IO8USB_LSFS_OTG_FT_USB
|75 PB14 IO8USB_LSFS_OTG_FT_NON_USB_DNV33
76 PB15 IO8USB_LSFS_OTG_FT_USB
|76 PB15 IO8USB_LSFS_OTG_FT_NON_USB_DPV3394
77 PD8 IO8PROG2M25M50M100M_ARSUDQ_FT
78 PD9 IO8PROG2M25M50M100M_ARSUDQ_FT
79 PD10 IO8PROG2M25M50M100M_ARSUDQ_FT
80 PD11 IO8PROG2M25M50M100M_ARSUDQ_FT
81 PD12 IO8PROG2M25M50M100M_ARSUDQ_FT
82 PD13 IO8PROG2M25M50M100M_ARSUDQ_FT
|83 VSS_8 VSSIOCO
|84 VDD_8 VDD33IOCO
85 PD14 IO8PROG2M25M50M100M_ARSUDQ_FT
86 PD15 IO8PROG2M25M50M100M_ARSUDQ_FT
87 PG2 IO8PROG2M25M50M100M_ARSUDQ_FT
88 PG3 IO8PROG2M25M50M100M_ARSUDQ_FT
89 PG4 IO8PROG2M25M50M100M_ARSUDQ_FT
90 PG5 IO8PROG2M25M50M100M_ARSUDQ_FT
91 PG6 IO8PROG2M25M50M100M_ARSUDQ_FT
92 PG7 IO8PROG2M25M50M100M_ARSUDQ_FT
93 PG8 IO8PROG2M25M50M100M_ARSUDQ_FT
|94 VSS_9 VSSIOCO
|95 VDD_9 VDD33IOCO
96 PC6 IO8PROG2M25M50M100M_ARSUDQ_FT
97 PC7 IO8PROG2M25M50M100M_ARSUDQ_FT
98 PC8 IO8PROG2M25M50M100M_ARSUDQ_FT
99 PC9 IO8PROG2M25M50M100M_ARSUDQ_I2CIN_FT
100 PA8 IO8PROG2M25M50M100M_ARSUDQ_I2CIN_FT
101 PA9 IO8USB_VBUS_OTG_FT
102 PA10 IO8USB_ID_OTG_FT
|103 PA11 IO8USB_LSFS_OTG_FT_USB
103 PA11 IO8USB_LSFS_OTG_FT_NON_USB_DNV33
|104 PA12 IO8USB_LSFS_OTG_FT_USB
104 PA12 IO8USB_LSFS_OTG_FT_NON_USB_DPV33
105 PA13 IO8PROG2M25M50M100M_ARSUDQ_FT
|106 VCAP_2
|107 VSS_2 VSSIOCO
|108 VDD_2 VDD33IOCO
|- PH13 IO8PROG2M25M50M100M_ARSUDQ_FT
|- PH14 IO8PROG2M25M50M100M_ARSUDQ_FT
|- PH15 IO8PROG2M25M50M100M_ARSUDQ_FT
|- PI0 IO8PROG2M25M50M100M_ARSUDQ_FT
|- PI1 IO8PROG2M25M50M100M_ARSUDQ_FT
|- PI2 IO8PROG2M25M50M100M_ARSUDQ_FT
|- PI3 IO8PROG2M25M50M100M_ARSUDQ_FT
|- VSS_15 VSSIOCO
|- VDD_15 VDD33IOCO
109 PA14 IO8PROG2M25M50M100M_ARSUDQ_FT
110 PA15 IO8PROG2M25M50M100M_AR3WSUDQ_FT
111 PC10 IO8PROG2M25M50M100M_ARSUDQ_FT
112 PC11 IO8PROG2M25M50M100M_ARSUDQ_FT
113 PC12 IO8PROG2M25M50M100M_ARSUDQ_FT
114 PD0 IO8PROG2M25M50M100M_ARSUDQ_FT
115 PD1 IO8PROG2M25M50M100M_ARSUDQ_FT
116 PD2 IO8PROG2M25M50M100M_ARSUDQ_FT
117 PD3 IO8PROG2M25M50M100M_ARSUDQ_FT
118 PD4 IO8PROG2M25M50M100M_ARSUDQ_FT
119 PD5 IO8PROG2M25M50M100M_ARSUDQ_FT
|120 VSS_10 VSSIOCO
|121 VDD_10 VDD33IOCO
122 PD6 IO8PROG2M25M50M100M_ARSUDQ_FT
123 PD7 IO8PROG2M25M50M100M_ARSUDQ_FT
124 PG9 IO8PROG2M25M50M100M_ARSUDQ_FT
125 PG10 IO8PROG2M25M50M100M_ARSUDQ_FT
126 PG11 IO8PROG2M25M50M100M_ARSUDQ_FT
127 PG12 IO8PROG2M25M50M100M_ARSUDQ_FT
128 PG13 IO8PROG2M25M50M100M_ARSUDQ_FT
129 PG14 IO8PROG2M25M50M100M_ARSUDQ_FT
|130 VSS_11 VSSIOCO
|131 VDD_11 VDD33IOCO
132 PG15 IO8PROG2M25M50M100M_ARSUDQ_FT
133 PB3 IO8PROG2M25M50M100M_ARSUDQ_FT
134 PB4 IO8PROG2M25M50M100M_ARSUDQ_FT
135 PB5 IO8PROG2M25M50M100M_AR3WSUDQ_FT
136 PB6 IO8PROG2M25M50M100M_ARSUDQ_I2CIN_FT
137 PB7 IO8PROG2M25M50M100M_ARSUDQ_I2CIN_FT
138 BOOT0 VPP_TEST_HV
139 PB8 IO8PROG2M25M50M100M_ARSUDQ_I2CIN_FT
140 PB9 IO8PROG2M25M50M100M_ARSUDQ_I2CIN_FT
141 PE0 IO8PROG2M25M50M100M_ARSUDQ_FT
142 PE1 IO8PROG2M25M50M100M_ARSUDQ_FT
|- VSS VSSIOCO
|143 RFU VSSIOCO
|144 VDD_3 VDD33IOCO
|- PI4 IO8PROG2M25M50M100M_ARSUDQ_FT
|- PI5 IO8PROG2M25M50M100M_ARSUDQ_FT
|- PI6 IO8PROG2M25M50M100M_ARSUDQ_FT
|- PI7 IO8PROG2M25M50M100M_ARSUDQ_FT
[Diff Pin]  inv_pin   vdiff tdelay_typ tdelay_min tdelay_max
75 76 200mV 0  0 0
103 104 200mV 0  0 0
[Model Selector] IO8PROG2M25M50M100M_AR3WSUDQ_FT_V33
IO8PROG2M25M50M100M_AR3WSUDQ_DRV_V33_00   DRIVER MODEL  : SPEEDAV33=0 SPEEDBV33=0
IO8PROG2M25M50M100M_AR3WSUDQ_DRV_V33_01   DRIVER MODEL  : SPEEDAV33=0 SPEEDBV33=1
IO8PROG2M25M50M100M_AR3WSUDQ_DRV_V33_10   DRIVER MODEL  : SPEEDAV33=1 SPEEDBV33=0
IO8PROG2M25M50M100M_AR3WSUDQ_DRV_V33_11   DRIVER MODEL  : SPEEDAV33=1 SPEEDBV33=1
IO8PROG2M25M50M100M_AR3WSUDQ_RCV_V33_0   CMOS RECIEVER : ENHYSV33=0  OUTPUT=ZIV33
IO8PROG2M25M50M100M_AR3WSUDQ_RCV_V33_0_T  TTL  RECIEVER : ENHYSV33=0  OUTPUT=ZIV33
IO8PROG2M25M50M100M_AR3WSUDQ_RCV_V33_1   CMOS RECIEVER : ENHYSV33=1  OUTPUT=ZIV33
IO8PROG2M25M50M100M_AR3WSUDQ_RCV_V33_1_T  TTL  RECIEVER : ENHYSV33=1  OUTPUT=ZIV33
[Model Selector] IO8PROG2M25M50M100M_AR3WSUDQ_FT
IO8PROG2M25M50M100M_AR3WSUDQ_FT_DRV_00   DRIVER MODEL  : SPEEDAV12=0 SPEEDBV12=0
IO8PROG2M25M50M100M_AR3WSUDQ_FT_DRV_01   DRIVER MODEL  : SPEEDAV12=0 SPEEDBV12=1
IO8PROG2M25M50M100M_AR3WSUDQ_FT_DRV_10   DRIVER MODEL  : SPEEDAV12=1 SPEEDBV12=0
IO8PROG2M25M50M100M_AR3WSUDQ_FT_DRV_11   DRIVER MODEL  : SPEEDAV12=1 SPEEDBV12=1
IO8PROG2M25M50M100M_AR3WSUDQ_FT_RCV_00   CMOS RECIEVER : ENHYSV12=0  OUTPUT=ZIV12
IO8PROG2M25M50M100M_AR3WSUDQ_FT_RCV_00_T  TTL  RECIEVER : ENHYSV12=0  OUTPUT=ZIV12
IO8PROG2M25M50M100M_AR3WSUDQ_FT_RCV_01   CMOS RECIEVER : ENHYSV12=0  OUTPUT=ZIV33
IO8PROG2M25M50M100M_AR3WSUDQ_FT_RCV_01_T  TTL  RECIEVER : ENHYSV12=0  OUTPUT=ZIV33
IO8PROG2M25M50M100M_AR3WSUDQ_FT_RCV_10   CMOS RECIEVER : ENHYSV12=1  OUTPUT=ZIV12
IO8PROG2M25M50M100M_AR3WSUDQ_FT_RCV_10_T  TTL  RECIEVER : ENHYSV12=1  OUTPUT=ZIV12
IO8PROG2M25M50M100M_AR3WSUDQ_FT_RCV_11   CMOS RECIEVER : ENHYSV12=1  OUTPUT=ZIV33
IO8PROG2M25M50M100M_AR3WSUDQ_FT_RCV_11_T  TTL  RECIEVER : ENHYSV12=1  OUTPUT=ZIV33
[Model Selector] IO8PROG2M25M50M100M_ARSUDQ_FT
IO8PROG2M25M50M100M_ARSUDQ_FT_DRV_00   DRIVER MODEL  : SPEEDAV12=0 SPEEDBV12=0
IO8PROG2M25M50M100M_ARSUDQ_FT_DRV_01   DRIVER MODEL  : SPEEDAV12=0 SPEEDBV12=1
IO8PROG2M25M50M100M_ARSUDQ_FT_DRV_10   DRIVER MODEL  : SPEEDAV12=1 SPEEDBV12=0
IO8PROG2M25M50M100M_ARSUDQ_FT_DRV_11   DRIVER MODEL  : SPEEDAV12=1 SPEEDBV12=1
IO8PROG2M25M50M100M_ARSUDQ_FT_RCV_00   CMOS RECIEVER : ENHYSV12=0  OUTPUT=ZIV12
IO8PROG2M25M50M100M_ARSUDQ_FT_RCV_00_T   TTL  RECIEVER : ENHYSV12=0  OUTPUT=ZIV12
IO8PROG2M25M50M100M_ARSUDQ_FT_RCV_01   CMOS RECIEVER : ENHYSV12=0  OUTPUT=ZIV33
IO8PROG2M25M50M100M_ARSUDQ_FT_RCV_01_T   TTL  RECIEVER : ENHYSV12=0  OUTPUT=ZIV33
IO8PROG2M25M50M100M_ARSUDQ_FT_RCV_10   CMOS RECIEVER : ENHYSV12=1  OUTPUT=ZIV12
IO8PROG2M25M50M100M_ARSUDQ_FT_RCV_10_T   TTL  RECIEVER : ENHYSV12=1  OUTPUT=ZIV12
IO8PROG2M25M50M100M_ARSUDQ_FT_RCV_11   CMOS RECIEVER : ENHYSV12=1  OUTPUT=ZIV33
IO8PROG2M25M50M100M_ARSUDQ_FT_RCV_11_T   TTL  RECIEVER : ENHYSV12=1  OUTPUT=ZIV33
[Model Selector] IO8PROG2M25M50M100M_ARSUDQ_I2CIN_FT
IO8PROG2M25M50M100M_ARSUDQ_I2CIN_DRV_00   DRIVER MODEL  : SPEEDAV12=0 SPEEDBV12=0
IO8PROG2M25M50M100M_ARSUDQ_I2CIN_DRV_01   DRIVER MODEL  : SPEEDAV12=0 SPEEDBV12=1
IO8PROG2M25M50M100M_ARSUDQ_I2CIN_DRV_10   DRIVER MODEL  : SPEEDAV12=1 SPEEDBV12=0
IO8PROG2M25M50M100M_ARSUDQ_I2CIN_DRV_11   DRIVER MODEL  : SPEEDAV12=1 SPEEDBV12=1
IO8PROG2M25M50M100M_I2CIN_RCV_ZII2C_00   CMOS RECIEVER : TESTI2CV12=0  HSFSV12=0
IO8PROG2M25M50M100M_I2CIN_RCV_ZII2C_00_T   TTL  RECIEVER : TESTI2CV12=0  HSFSV12=0
IO8PROG2M25M50M100M_I2CIN_RCV_ZII2C_01   CMOS RECIEVER : TESTI2CV12=0  HSFSV12=1
IO8PROG2M25M50M100M_I2CIN_RCV_ZII2C_01_T   TTL  RECIEVER : TESTI2CV12=0  HSFSV12=1
IO8PROG2M25M50M100M_I2CIN_RCV_ZII2C_10   CMOS RECIEVER : TESTI2CV12=1  HSFSV12=0
IO8PROG2M25M50M100M_I2CIN_RCV_ZII2C_10_T   TTL  RECIEVER : TESTI2CV12=1  HSFSV12=0
IO8PROG2M25M50M100M_I2CIN_RCV_ZII2C_11   CMOS RECIEVER : TESTI2CV12=1  HSFSV12=1
IO8PROG2M25M50M100M_I2CIN_RCV_ZII2C_11_T   TTL  RECIEVER : TESTI2CV12=1  HSFSV12=1
IO8PROG2M25M50M100M_I2CIN_RCV_ZIV12_0   CMOS RECIEVER : ENHYSV12=0  OUTPUT=ZIV12
IO8PROG2M25M50M100M_I2CIN_RCV_ZIV12_0_T   TTL  RECIEVER : ENHYSV12=0  OUTPUT=ZIV12
IO8PROG2M25M50M100M_I2CIN_RCV_ZIV12_1   CMOS RECIEVER : ENHYSV12=1  OUTPUT=ZIV12
IO8PROG2M25M50M100M_I2CIN_RCV_ZIV12_1_T   TTL  RECIEVER : ENHYSV12=1  OUTPUT=ZIV12
IO8PROG2M25M50M100M_I2CIN_RCV_ZIV33_0   CMOS RECIEVER : ENHYSV12=0  OUTPUT=ZIV33
IO8PROG2M25M50M100M_I2CIN_RCV_ZIV33_0_T   TTL  RECIEVER : ENHYSV12=0  OUTPUT=ZIV33
IO8PROG2M25M50M100M_I2CIN_RCV_ZIV33_1   CMOS RECIEVER : ENHYSV12=1  OUTPUT=ZIV33
IO8PROG2M25M50M100M_I2CIN_RCV_ZIV33_1_T   TTL  RECIEVER : ENHYSV12=1  OUTPUT=ZIV33
[Model Selector] IO8PROG2M25M50M100M_ARWSUDQ_FT_V33
IO8PROG2M25M50M100M_ARWSUDQ_DRV_V33_00   DRIVER MODEL  : SPEEDAV33=0 SPEEDBV33=0
IO8PROG2M25M50M100M_ARWSUDQ_DRV_V33_01   DRIVER MODEL  : SPEEDAV33=0 SPEEDBV33=1
IO8PROG2M25M50M100M_ARWSUDQ_DRV_V33_10   DRIVER MODEL  : SPEEDAV33=1 SPEEDBV33=0
IO8PROG2M25M50M100M_ARWSUDQ_DRV_V33_11   DRIVER MODEL  : SPEEDAV33=1 SPEEDBV33=1
IO8PROG2M25M50M100M_ARWSUDQ_RCV_V33_0   CMOS RECIEVER : ENHYSV33=0  OUTPUT=ZIV33
IO8PROG2M25M50M100M_ARWSUDQ_RCV_V33_0_T   TTL  RECIEVER : ENHYSV33=0  OUTPUT=ZIV33
IO8PROG2M25M50M100M_ARWSUDQ_RCV_V33_1   CMOS RECIEVER : ENHYSV33=1  OUTPUT=ZIV33
IO8PROG2M25M50M100M_ARWSUDQ_RCV_V33_1_T   TTL  RECIEVER : ENHYSV33=1  OUTPUT=ZIV33
[Model Selector] IO8PROG2M25M50M100M_ARWSUDQ_FT
IO8PROG2M25M50M100M_ARWSUDQ_FT_DRV_00   DRIVER MODEL  : SPEEDAV12=0 SPEEDBV12=0
IO8PROG2M25M50M100M_ARWSUDQ_FT_DRV_01   DRIVER MODEL  : SPEEDAV12=0 SPEEDBV12=1
IO8PROG2M25M50M100M_ARWSUDQ_FT_DRV_10   DRIVER MODEL  : SPEEDAV12=1 SPEEDBV12=0
IO8PROG2M25M50M100M_ARWSUDQ_FT_DRV_11   DRIVER MODEL  : SPEEDAV12=1 SPEEDBV12=1
IO8PROG2M25M50M100M_ARWSUDQ_FT_RCV_00   CMOS RECIEVER : ENHYSV12=0  OUTPUT=ZIV12
IO8PROG2M25M50M100M_ARWSUDQ_FT_RCV_00_T   TTL  RECIEVER : ENHYSV12=0  OUTPUT=ZIV12
IO8PROG2M25M50M100M_ARWSUDQ_FT_RCV_01   CMOS RECIEVER : ENHYSV12=0  OUTPUT=ZIV33
IO8PROG2M25M50M100M_ARWSUDQ_FT_RCV_01_T   TTL  RECIEVER : ENHYSV12=0  OUTPUT=ZIV33
IO8PROG2M25M50M100M_ARWSUDQ_FT_RCV_10   CMOS RECIEVER : ENHYSV12=1  OUTPUT=ZIV12
IO8PROG2M25M50M100M_ARWSUDQ_FT_RCV_10_T   TTL  RECIEVER : ENHYSV12=1  OUTPUT=ZIV12
IO8PROG2M25M50M100M_ARWSUDQ_FT_RCV_11   CMOS RECIEVER : ENHYSV12=1  OUTPUT=ZIV33
IO8PROG2M25M50M100M_ARWSUDQ_FT_RCV_11_T   TTL  RECIEVER : ENHYSV12=1  OUTPUT=ZIV33
[Model Selector] IO8USB_ID_OTG_FT
IO8USB_ID_OTG_FT_DRV_00   DRIVER MODEL  : SPEEDAV12=0 SPEEDBV12=0
IO8USB_ID_OTG_FT_DRV_01   DRIVER MODEL  : SPEEDAV12=0 SPEEDBV12=1
IO8USB_ID_OTG_FT_DRV_10   DRIVER MODEL  : SPEEDAV12=1 SPEEDBV12=0
IO8USB_ID_OTG_FT_DRV_11   DRIVER MODEL  : SPEEDAV12=1 SPEEDBV12=1
IO8USB_ID_OTG_FT_RCV_00   CMOS RECIEVER : ENHYSV12=0  OUTPUT=ZIV12
IO8USB_ID_OTG_FT_RCV_00_T   TTL  RECIEVER : ENHYSV12=0  OUTPUT=ZIV12
IO8USB_ID_OTG_FT_RCV_01   CMOS RECIEVER : ENHYSV12=0  OUTPUT=ZIV33
IO8USB_ID_OTG_FT_RCV_01_T   TTL  RECIEVER : ENHYSV12=0  OUTPUT=ZIV33
IO8USB_ID_OTG_FT_RCV_10   CMOS RECIEVER : ENHYSV12=1  OUTPUT=ZIV12
IO8USB_ID_OTG_FT_RCV_10_T   TTL  RECIEVER : ENHYSV12=1  OUTPUT=ZIV12
IO8USB_ID_OTG_FT_RCV_11   CMOS RECIEVER : ENHYSV12=1  OUTPUT=ZIV33
IO8USB_ID_OTG_FT_RCV_11_T   TTL  RECIEVER : ENHYSV12=1  OUTPUT=ZIV33
[Model Selector] IO8USB_LSFS_OTG_FT_USB
IO8USB_LSFS_OTG_FT_DRV_USB_0   DRIVER : USBLSFSV12=0 ENUSBV12=0
IO8USB_LSFS_OTG_FT_DRV_USB_1   DRIVER : USBLSFSV12=1 ENUSBV12=0
IO8USB_LSFS_OTG_FT_RCV_USB   USB  RECIEVER : ENHYSV12=1  OUTPUT=USBZIV12
[Model Selector] IO8USB_LSFS_OTG_FT_NON_USB_DNV33
IO8USB_LSFS_OTG_FT_DRV_IO8_DNV33_00   DRIVER : SPEEDAV12=0 SPEEDBV12=0 ENUSBV12=1
IO8USB_LSFS_OTG_FT_DRV_IO8_DNV33_01   DRIVER : SPEEDAV12=0 SPEEDBV12=1 ENUSBV12=1
IO8USB_LSFS_OTG_FT_DRV_IO8_DNV33_10   DRIVER : SPEEDAV12=1 SPEEDBV12=0 ENUSBV12=1
IO8USB_LSFS_OTG_FT_DRV_IO8_DNV33_11   DRIVER : SPEEDAV12=1 SPEEDBV12=1 ENUSBV12=1
IO8USB_LSFS_OTG_FT_RCV_IO8_ZINV12_0   CMOS RECIEVER : ENHYSV12=0  OUTPUT=ZIV12
IO8USB_LSFS_OTG_FT_RCV_IO8_ZINV12_0_T  TTL  RECIEVER : ENHYSV12=0  OUTPUT=ZIV12
IO8USB_LSFS_OTG_FT_RCV_IO8_ZINV12_1   CMOS RECIEVER : ENHYSV12=1  OUTPUT=ZIV12
IO8USB_LSFS_OTG_FT_RCV_IO8_ZINV12_1_T  TTL  RECIEVER : ENHYSV12=1  OUTPUT=ZIV12
IO8USB_LSFS_OTG_FT_RCV_IO8_ZINV33_0   CMOS RECIEVER : ENHYSV12=0  OUTPUT=ZIV33
IO8USB_LSFS_OTG_FT_RCV_IO8_ZINV33_0_T  TTL  RECIEVER : ENHYSV12=0  OUTPUT=ZIV33
IO8USB_LSFS_OTG_FT_RCV_IO8_ZINV33_1   CMOS RECIEVER : ENHYSV12=1  OUTPUT=ZIV33
IO8USB_LSFS_OTG_FT_RCV_IO8_ZINV33_1_T  TTL  RECIEVER : ENHYSV12=1  OUTPUT=ZIV33
[Model Selector] IO8USB_LSFS_OTG_FT_NON_USB_DPV33
IO8USB_LSFS_OTG_FT_DRV_IO8_DPV33_00   DRIVER : SPEEDAV12=0 SPEEDBV12=0 ENUSBV12=1
IO8USB_LSFS_OTG_FT_DRV_IO8_DPV33_01   DRIVER : SPEEDAV12=0 SPEEDBV12=1 ENUSBV12=1
IO8USB_LSFS_OTG_FT_DRV_IO8_DPV33_10   DRIVER : SPEEDAV12=1 SPEEDBV12=0 ENUSBV12=1
IO8USB_LSFS_OTG_FT_DRV_IO8_DPV33_11   DRIVER : SPEEDAV12=1 SPEEDBV12=1 ENUSBV12=1
IO8USB_LSFS_OTG_FT_RCV_IO8_ZIPV12_0   CMOS RECIEVER : ENHYSV12=0  OUTPUT=ZIV12
IO8USB_LSFS_OTG_FT_RCV_IO8_ZIPV12_0_T  TTL  RECIEVER : ENHYSV12=0  OUTPUT=ZIV12
IO8USB_LSFS_OTG_FT_RCV_IO8_ZIPV12_1   CMOS RECIEVER : ENHYSV12=1  OUTPUT=ZIV12
IO8USB_LSFS_OTG_FT_RCV_IO8_ZIPV12_1_T  TTL  RECIEVER : ENHYSV12=1  OUTPUT=ZIV12
IO8USB_LSFS_OTG_FT_RCV_IO8_ZIPV33_0   CMOS RECIEVER : ENHYSV12=0  OUTPUT=ZIV33
IO8USB_LSFS_OTG_FT_RCV_IO8_ZIPV33_0_T  TTL  RECIEVER : ENHYSV12=0  OUTPUT=ZIV33
IO8USB_LSFS_OTG_FT_RCV_IO8_ZIPV33_1   CMOS RECIEVER : ENHYSV12=1  OUTPUT=ZIV33
IO8USB_LSFS_OTG_FT_RCV_IO8_ZIPV33_1_T  TTL  RECIEVER : ENHYSV12=1  OUTPUT=ZIV33
[Model Selector] IO8USB_VBUS_OTG_FT
IO8USB_VBUS_OTG_FT_DRV_00   DRIVER MODEL  : SPEEDAV12=0 SPEEDBV12=0
IO8USB_VBUS_OTG_FT_DRV_01   DRIVER MODEL  : SPEEDAV12=0 SPEEDBV12=1
IO8USB_VBUS_OTG_FT_DRV_10   DRIVER MODEL  : SPEEDAV12=1 SPEEDBV12=0
IO8USB_VBUS_OTG_FT_DRV_11   DRIVER MODEL  : SPEEDAV12=1 SPEEDBV12=1
IO8USB_VBUS_OTG_FT_RCV_00   CMOS RECIEVER : ENHYSV12=0  OUTPUT=ZIV12
IO8USB_VBUS_OTG_FT_RCV_00_T   TTL  RECIEVER : ENHYSV12=0  OUTPUT=ZIV12
IO8USB_VBUS_OTG_FT_RCV_01   CMOS RECIEVER : ENHYSV12=0  OUTPUT=ZIV33
IO8USB_VBUS_OTG_FT_RCV_01_T   TTL  RECIEVER : ENHYSV12=0  OUTPUT=ZIV33
IO8USB_VBUS_OTG_FT_RCV_10   CMOS RECIEVER : ENHYSV12=1  OUTPUT=ZIV12
IO8USB_VBUS_OTG_FT_RCV_10_T   TTL  RECIEVER : ENHYSV12=1  OUTPUT=ZIV12
IO8USB_VBUS_OTG_FT_RCV_11   CMOS RECIEVER : ENHYSV12=1  OUTPUT=ZIV33
IO8USB_VBUS_OTG_FT_RCV_11_T   TTL  RECIEVER : ENHYSV12=1  OUTPUT=ZIV33
[Model Selector] VPP_TEST_HV
VPP_TEST_HV_00   CMOS RECIEVER : ENHYSV12=0  OUTPUT=ZIV12
VPP_TEST_HV_00_T   TTL  RECIEVER : ENHYSV12=0  OUTPUT=ZIV12
VPP_TEST_HV_01   CMOS RECIEVER : ENHYSV12=0  OUTPUT=ZIV33
VPP_TEST_HV_01_T   TTL  RECIEVER : ENHYSV12=0  OUTPUT=ZIV33
VPP_TEST_HV_10   CMOS RECIEVER : ENHYSV12=1  OUTPUT=ZIV12
VPP_TEST_HV_10_T   TTL  RECIEVER : ENHYSV12=1  OUTPUT=ZIV12
VPP_TEST_HV_11   CMOS RECIEVER : ENHYSV12=1  OUTPUT=ZIV33
VPP_TEST_HV_11_T   TTL  RECIEVER : ENHYSV12=1  OUTPUT=ZIV33
| Models and submodels in the file (131): IO8PROG2M25M50M100M_AR3WSUDQ_DRV_V33_00 (3-state), IO8PROG2M25M50M100M_AR3WSUDQ_DRV_V33_01 (3-state), IO8PROG2M25M50M100M_AR3WSUDQ_DRV_V33_10 (3-state), IO8PROG2M25M50M100M_AR3WSUDQ_DRV_V33_11 (3-state), IO8PROG2M25M50M100M_AR3WSUDQ_FT_DRV_00 (3-state), IO8PROG2M25M50M100M_AR3WSUDQ_FT_DRV_01 (3-state), IO8PROG2M25M50M100M_AR3WSUDQ_FT_DRV_10 (3-state), IO8PROG2M25M50M100M_AR3WSUDQ_FT_DRV_11 (3-state), IO8PROG2M25M50M100M_AR3WSUDQ_FT_RCV_00 (Input), IO8PROG2M25M50M100M_AR3WSUDQ_FT_RCV_00_T (Input), IO8PROG2M25M50M100M_AR3WSUDQ_FT_RCV_01 (Input), IO8PROG2M25M50M100M_AR3WSUDQ_FT_RCV_01_T (Input), IO8PROG2M25M50M100M_AR3WSUDQ_FT_RCV_10 (Input), IO8PROG2M25M50M100M_AR3WSUDQ_FT_RCV_10_T (Input), IO8PROG2M25M50M100M_AR3WSUDQ_FT_RCV_11 (Input), IO8PROG2M25M50M100M_AR3WSUDQ_FT_RCV_11_T (Input), IO8PROG2M25M50M100M_AR3WSUDQ_RCV_V33_0 (Input), IO8PROG2M25M50M100M_AR3WSUDQ_RCV_V33_0_T (Input), IO8PROG2M25M50M100M_AR3WSUDQ_RCV_V33_1 (Input), IO8PROG2M25M50M100M_AR3WSUDQ_RCV_V33_1_T (Input), IO8PROG2M25M50M100M_ARSUDQ_FT_DRV_00 (3-state), IO8PROG2M25M50M100M_ARSUDQ_FT_DRV_01 (3-state), IO8PROG2M25M50M100M_ARSUDQ_FT_DRV_10 (3-state), IO8PROG2M25M50M100M_ARSUDQ_FT_DRV_11 (3-state), IO8PROG2M25M50M100M_ARSUDQ_FT_RCV_00 (Input), IO8PROG2M25M50M100M_ARSUDQ_FT_RCV_00_T (Input), IO8PROG2M25M50M100M_ARSUDQ_FT_RCV_01 (Input), IO8PROG2M25M50M100M_ARSUDQ_FT_RCV_01_T (Input), IO8PROG2M25M50M100M_ARSUDQ_FT_RCV_10 (Input), IO8PROG2M25M50M100M_ARSUDQ_FT_RCV_10_T (Input), IO8PROG2M25M50M100M_ARSUDQ_FT_RCV_11 (Input), IO8PROG2M25M50M100M_ARSUDQ_FT_RCV_11_T (Input), IO8PROG2M25M50M100M_ARSUDQ_I2CIN_DRV_00 (3-state), IO8PROG2M25M50M100M_ARSUDQ_I2CIN_DRV_01 (3-state), IO8PROG2M25M50M100M_ARSUDQ_I2CIN_DRV_10 (3-state), IO8PROG2M25M50M100M_ARSUDQ_I2CIN_DRV_11 (3-state), IO8PROG2M25M50M100M_ARWSUDQ_DRV_V33_00 (3-state), IO8PROG2M25M50M100M_ARWSUDQ_DRV_V33_01 (3-state), IO8PROG2M25M50M100M_ARWSUDQ_DRV_V33_10 (3-state), IO8PROG2M25M50M100M_ARWSUDQ_DRV_V33_11 (3-state), IO8PROG2M25M50M100M_ARWSUDQ_FT_DRV_00 (3-state), IO8PROG2M25M50M100M_ARWSUDQ_FT_DRV_01 (3-state), IO8PROG2M25M50M100M_ARWSUDQ_FT_DRV_10 (3-state), IO8PROG2M25M50M100M_ARWSUDQ_FT_DRV_11 (3-state), IO8PROG2M25M50M100M_ARWSUDQ_FT_RCV_00 (Input), IO8PROG2M25M50M100M_ARWSUDQ_FT_RCV_00_T (Input), IO8PROG2M25M50M100M_ARWSUDQ_FT_RCV_01 (Input), IO8PROG2M25M50M100M_ARWSUDQ_FT_RCV_01_T (Input), IO8PROG2M25M50M100M_ARWSUDQ_FT_RCV_10 (Input), IO8PROG2M25M50M100M_ARWSUDQ_FT_RCV_10_T (Input), IO8PROG2M25M50M100M_ARWSUDQ_FT_RCV_11 (Input), IO8PROG2M25M50M100M_ARWSUDQ_FT_RCV_11_T (Input), IO8PROG2M25M50M100M_ARWSUDQ_RCV_V33_0 (Input), IO8PROG2M25M50M100M_ARWSUDQ_RCV_V33_0_T (Input), IO8PROG2M25M50M100M_ARWSUDQ_RCV_V33_1 (Input), IO8PROG2M25M50M100M_ARWSUDQ_RCV_V33_1_T (Input), IO8PROG2M25M50M100M_I2CIN_RCV_ZII2C_00 (Input), IO8PROG2M25M50M100M_I2CIN_RCV_ZII2C_00_T (Input), IO8PROG2M25M50M100M_I2CIN_RCV_ZII2C_01 (Input), IO8PROG2M25M50M100M_I2CIN_RCV_ZII2C_01_T (Input), IO8PROG2M25M50M100M_I2CIN_RCV_ZII2C_10 (Input), IO8PROG2M25M50M100M_I2CIN_RCV_ZII2C_10_T (Input), IO8PROG2M25M50M100M_I2CIN_RCV_ZII2C_11 (Input), IO8PROG2M25M50M100M_I2CIN_RCV_ZII2C_11_T (Input), IO8PROG2M25M50M100M_I2CIN_RCV_ZIV12_0 (Input), IO8PROG2M25M50M100M_I2CIN_RCV_ZIV12_0_T (Input), IO8PROG2M25M50M100M_I2CIN_RCV_ZIV12_1 (Input), IO8PROG2M25M50M100M_I2CIN_RCV_ZIV12_1_T (Input), IO8PROG2M25M50M100M_I2CIN_RCV_ZIV33_0 (Input), IO8PROG2M25M50M100M_I2CIN_RCV_ZIV33_0_T (Input), IO8PROG2M25M50M100M_I2CIN_RCV_ZIV33_1 (Input), IO8PROG2M25M50M100M_I2CIN_RCV_ZIV33_1_T (Input), IO8USB_ID_OTG_FT_DRV_00 (3-state), IO8USB_ID_OTG_FT_DRV_01 (3-state), IO8USB_ID_OTG_FT_DRV_10 (3-state), IO8USB_ID_OTG_FT_DRV_11 (3-state), IO8USB_ID_OTG_FT_RCV_00 (Input), IO8USB_ID_OTG_FT_RCV_00_T (Input), IO8USB_ID_OTG_FT_RCV_01 (Input), IO8USB_ID_OTG_FT_RCV_01_T (Input)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
