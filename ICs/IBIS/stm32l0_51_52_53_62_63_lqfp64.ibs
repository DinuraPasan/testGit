| IBIS file stm32l0_51_52_53_62_63_lqfp64.ibs
| Created by s2ibis version 1.1 (customized version)
| North Carolina State University, ERL, 2006
[IBIS ver] 4.2
[File name] stm32l0_51_52_53_62_63_lqfp64.ibs
[File Rev] 1.0
[Date]  15-10-2014
[Source] Data Created at STMicroelectronics
[Notes]  File originated from ELDO simulations.
[Disclaimer]  This information is for modeling purpose only and is
   not guaranted. The information is subject to change without
   notice.
[Copyright] Copyright 2016 STMicroelectronics Inc.
|   Component stm32l0_51_52_53_62_63_lqfp64
[Component] stm32l0_51_52_53_62_63_lqfp64
[Manufacturer] STMicroelectronics
[Package]
| variable   typ   min   max
R_pkg   0.0   0.0   0.0
L_pkg   0.0H   0.0H   0.0H
C_pkg   0.0F   0.0F   0.0F
[Pin]  signal_name   model_name   R_pin   L_pin   C_pin
1 VLCD POWER 68.980E-3 4.220E-9 120.000E-15
2 PC13 io8p_wsudq_ls_ft_v33 63.756E-3 3.679E-9 93.469E-15
3 PC14-OSC32_IN io8p_wsudq_ls_ft_v33 59.336E-3 3.221E-9 71.020E-15
4 PC15-OSC32_OUT io8p_sudq_ls_tc_esdft 55.719E-3 2.846E-9 52.653E-15
5 PH0-OSC_IN io8p_sudq_ls_tc_esdft 52.907E-3 2.555E-9 38.367E-15
6 PH1-OSC_OUT io8p_sudq_ls_tc_esdft 50.897E-3 2.347E-9 28.163E-15
7 NRST ioreset_tc_v33_esdft 49.692E-3 2.222E-9 22.041E-15
8 PC0 io8p_wsudq_lcd4_ls_ft 49.290E-3 2.180E-9 20.000E-15
9 PC1 io8p_wsudq_lcd4_ls_ft 49.290E-3 2.180E-9 20.000E-15
10 PC2 io8p_wsudq_lcd4_ls_ft 49.692E-3 2.222E-9 22.041E-15
11 PC3 io8p_wsudq_lcd4_ls_ft 50.897E-3 2.347E-9 28.163E-15
12 VSSA GND 52.907E-3 2.555E-9 38.367E-15
13 VDDA POWER 55.719E-3 2.846E-9 52.653E-15
14 PA0 io8p_wsudq_ls_ft_v33 59.336E-3 3.221E-9 71.020E-15
15 PA1 io8p_wsudq_lcd4_ls_ft 63.756E-3 3.679E-9 93.469E-15
16 PA2 io8p_wsudq_lcd4_ls_ft 68.980E-3 4.220E-9 120.000E-15
17 PA3 io8p_wsudq_lcd4_ls_ft 68.980E-3 4.220E-9 120.000E-15
18 VSS GND 63.756E-3 3.679E-9 93.469E-15
19 VDD POWER 59.336E-3 3.221E-9 71.020E-15
20 PA4 io8p_wsudq_i2cin_ls_ft 55.719E-3 2.846E-9 52.653E-15
21 PA5 io8p_wsudq_i2cin_ls_ft 52.907E-3 2.555E-9 38.367E-15
22 PA6 io8p_wsudq_lcd4_ls_ft 50.897E-3 2.347E-9 28.163E-15
23 PA7 io8p_wsudq_lcd4_ls_ft 49.692E-3 2.222E-9 22.041E-15
24 PC4 io8p_wsudq_lcd4_ls_ft 49.290E-3 2.180E-9 20.000E-15
25 PC5 io8p_wsudq_lcd4_ls_ft 49.290E-3 2.180E-9 20.000E-15
26 PB0 io8p_wsudq_lcd4_ls_ft 49.692E-3 2.222E-9 22.041E-15
27 PB1 io8p_wsudq_lcd4_ls_ft 50.897E-3 2.347E-9 28.163E-15
28 PB2 io8p_wsudq_lcd4_ls_ft 52.907E-3 2.555E-9 38.367E-15
29 PB10 io8p_sudq_lcd4_i2cin_ls_ft 55.719E-3 2.846E-9 52.653E-15
30 PB11 io8p_sudq_lcd4_i2cin_ls_ft 59.336E-3 3.221E-9 71.020E-15
31 VSS GND 63.756E-3 3.679E-9 93.469E-15
32 VDD POWER 68.980E-3 4.220E-9 120.000E-15
33 PB12 io8p_wsudq_lcd4_ls_ft 68.980E-3 4.220E-9 120.000E-15
34 PB13 io8p_sudq_lcd4_i2cin_ls_ft 63.756E-3 3.679E-9 93.469E-15
35 PB14 io8p_sudq_lcd4_i2cin_ls_ft 59.336E-3 3.221E-9 71.020E-15
36 PB15 io8p_wsudq_lcd4_ls_ft 55.719E-3 2.846E-9 52.653E-15
37 PC6 io8p_wsudq_lcd4_ls_ft 52.907E-3 2.555E-9 38.367E-15
38 PC7 io8p_wsudq_lcd4_ls_ft 50.897E-3 2.347E-9 28.163E-15
39 PC8 io8p_wsudq_lcd4_ls_ft 49.692E-3 2.222E-9 22.041E-15
40 PC9 io8p_wsudq_lcd4_ls_ft 49.290E-3 2.180E-9 20.000E-15
41 PA8 io8p_wsudq_lcd4_ls_ft 49.290E-3 2.180E-9 20.000E-15
42 PA9 io8p_wsudq_lcd4_ls_ft 49.692E-3 2.222E-9 22.041E-15
43 PA10 io8p_wsudq_lcd4_ls_ft 50.897E-3 2.347E-9 28.163E-15
44 PA11 io8usb_ls_ft 52.907E-3 2.555E-9 38.367E-15
45 PA12 io8usb_ls_ft 55.719E-3 2.846E-9 52.653E-15
46 PA13 io8p_sudq_ls_ft 59.336E-3 3.221E-9 71.020E-15
47 VSS GND 63.756E-3 3.679E-9 93.469E-15
48 VDD_USB POWER 68.980E-3 4.220E-9 120.000E-15
49 PA14 io8p_sudq_ls_ft 68.980E-3 4.220E-9 120.000E-15
50 PA15 io8p_wsudq_lcd4_ls_ft 63.756E-3 3.679E-9 93.469E-15
51 PC10 io8p_wsudq_lcd4_ls_ft 59.336E-3 3.221E-9 71.020E-15
52 PC11 io8p_wsudq_lcd4_ls_ft 55.719E-3 2.846E-9 52.653E-15
53 PC12 io8p_wsudq_lcd4_ls_ft 52.907E-3 2.555E-9 38.367E-15
54 PD2 io8p_wsudq_lcd4_ls_ft 50.897E-3 2.347E-9 28.163E-15
55 PB3 io8p_wsudq_lcd4_ls_ft 49.692E-3 2.222E-9 22.041E-15
56 PB4 io8p_wsudq_lcd4_ls_ft 49.290E-3 2.180E-9 20.000E-15
57 PB5 io8p_wsudq_lcd4_ls_ft 49.290E-3 2.180E-9 20.000E-15
58 PB6 io8p_wsudq_i2cin_ls_ft 49.692E-3 2.222E-9 22.041E-15
59 PB7 io8p_wsudq_i2cin_ls_ft 50.897E-3 2.347E-9 28.163E-15
60 BOOT0 vpp_test_hv 52.907E-3 2.555E-9 38.367E-15
61 PB8 io8p_sudq_lcd4_i2cin_ls_ft 55.719E-3 2.846E-9 52.653E-15
62 PB9 io8p_sudq_lcd4_i2cin_ls_ft 59.336E-3 3.221E-9 71.020E-15
63 VSS GND 63.756E-3 3.679E-9 93.469E-15
64 VDD POWER 68.980E-3 4.220E-9 120.000E-15
[Model Selector] io8p_sudq_ls_ft
io8p00_sudq_ls_ft_pd_lv  "SPEED00 1P8V, PD=40kOhm"
io8p00_sudq_ls_ft_pu_lv  "SPEED00 1P8V, PU=40kOhm"
io8p00_sudq_ls_ft_lv  "SPEED00 1P8V"
io8p01_sudq_ls_ft_pd_lv  "SPEED01 1P8V, PD=40kOhm"
io8p01_sudq_ls_ft_pu_lv  "SPEED01 1P8V, PU=40kOhm"
io8p01_sudq_ls_ft_lv  "SPEED01 1P8V"
io8p10_sudq_ls_ft_pd_lv  "SPEED10 1P8V, PD=40kOhm"
io8p10_sudq_ls_ft_pu_lv  "SPEED10 1P8V, PU=40kOhm"
io8p10_sudq_ls_ft_lv  "SPEED10 1P8V"
io8p11_sudq_ls_ft_pd_lv  "SPEED11 1P8V, PD=40kOhm"
io8p11_sudq_ls_ft_pu_lv  "SPEED11 1P8V, PU=40kOhm"
io8p11_sudq_ls_ft_lv  "SPEED11 1P8V"
io8p00_sudq_ls_ft_pd  "SPEED00, PD=40kOhm"
io8p00_sudq_ls_ft_pu  "SPEED00, PU=40kOhm"
io8p00_sudq_ls_ft  "SPEED00"
io8p01_sudq_ls_ft_pd  "SPEED01, PD=40kOhm"
io8p01_sudq_ls_ft_pu  "SPEED01, PU=40kOhm"
io8p01_sudq_ls_ft  "SPEED01"
io8p10_sudq_ls_ft_pd  "SPEED10, PD=40kOhm"
io8p10_sudq_ls_ft_pu  "SPEED10, PU=40kOhm"
io8p10_sudq_ls_ft  "SPEED10"
io8p11_sudq_ls_ft_pd  "SPEED11, PD=40kOhm"
io8p11_sudq_ls_ft_pu  "SPEED11, PU=40kOhm"
io8p11_sudq_ls_ft  "SPEED11"
[Model Selector] io8p_sudq_ls_tc_esdft
io8p00_sudq_ls_tc_esdft_pd_lv  "SPEED00 1P8V, PD=40kOhm"
io8p00_sudq_ls_tc_esdft_pu_lv  "SPEED00 1P8V, PU=40kOhm"
io8p00_sudq_ls_tc_esdft_lv  "SPEED00 1P8V"
io8p01_sudq_ls_tc_esdft_pd_lv  "SPEED01 1P8V, PD=40kOhm"
io8p01_sudq_ls_tc_esdft_pu_lv  "SPEED01 1P8V, PU=40kOhm"
io8p01_sudq_ls_tc_esdft_lv  "SPEED01 1P8V"
io8p10_sudq_ls_tc_esdft_pd_lv  "SPEED10 1P8V, PD=40kOhm"
io8p10_sudq_ls_tc_esdft_pu_lv  "SPEED10 1P8V, PU=40kOhm"
io8p10_sudq_ls_tc_esdft_lv  "SPEED10 1P8V"
io8p11_sudq_ls_tc_esdft_pd_lv  "SPEED11 1P8V, PD=40kOhm"
io8p11_sudq_ls_tc_esdft_pu_lv  "SPEED11 1P8V, PU=40kOhm"
io8p11_sudq_ls_tc_esdft_lv  "SPEED11 1P8V"
io8p00_sudq_ls_tc_esdft_pd  "SPEED00, PD=40kOhm"
io8p00_sudq_ls_tc_esdft_pu  "SPEED00, PU=40kOhm"
io8p00_sudq_ls_tc_esdft  "SPEED00"
io8p01_sudq_ls_tc_esdft_pd  "SPEED01, PD=40kOhm"
io8p01_sudq_ls_tc_esdft_pu  "SPEED01, PU=40kOhm"
io8p01_sudq_ls_tc_esdft  "SPEED01"
io8p10_sudq_ls_tc_esdft_pd  "SPEED10, PD=40kOhm"
io8p10_sudq_ls_tc_esdft_pu  "SPEED10, PU=40kOhm"
io8p10_sudq_ls_tc_esdft  "SPEED10"
io8p11_sudq_ls_tc_esdft_pd  "SPEED11, PD=40kOhm"
io8p11_sudq_ls_tc_esdft_pu  "SPEED11, PU=40kOhm"
io8p11_sudq_ls_tc_esdft  "SPEED11"
[Model Selector] io8p_wsudq_i2cin_ls_ft
io8p00_wsudq_i2cin_ls_ft_pd_lv  "SPEED00 1P8V, PD=40kOhm"
io8p00_wsudq_i2cin_ls_ft_pu_lv  "SPEED00 1P8V, PU=40kOhm"
io8p00_wsudq_i2cin_ls_ft_lv  "SPEED00 1P8V"
io8p01_wsudq_i2cin_ls_ft_pd_lv  "SPEED01 1P8V, PD=40kOhm"
io8p01_wsudq_i2cin_ls_ft_pu_lv  "SPEED01 1P8V, PU=40kOhm"
io8p01_wsudq_i2cin_ls_ft_lv  "SPEED01 1P8V"
io8p10_wsudq_i2cin_ls_ft_pd_lv  "SPEED10 1P8V, PD=40kOhm"
io8p10_wsudq_i2cin_ls_ft_pu_lv  "SPEED10 1P8V, PU=40kOhm"
io8p10_wsudq_i2cin_ls_ft_lv  "SPEED10 1P8V"
io8p11_wsudq_i2cin_ls_ft_pd_lv  "SPEED11 1P8V, PD=40kOhm"
io8p11_wsudq_i2cin_ls_ft_pu_lv  "SPEED11 1P8V, PU=40kOhm"
io8p11_wsudq_i2cin_ls_ft_lv  "SPEED11 1P8V"
io8p00_wsudq_i2cin_ls_ft_pd  "SPEED00, PD=40kOhm"
io8p00_wsudq_i2cin_ls_ft_pu  "SPEED00, PU=40kOhm"
io8p00_wsudq_i2cin_ls_ft  "SPEED00"
io8p01_wsudq_i2cin_ls_ft_pd  "SPEED01, PD=40kOhm"
io8p01_wsudq_i2cin_ls_ft_pu  "SPEED01, PU=40kOhm"
io8p01_wsudq_i2cin_ls_ft  "SPEED01"
io8p10_wsudq_i2cin_ls_ft_pd  "SPEED10, PD=40kOhm"
io8p10_wsudq_i2cin_ls_ft_pu  "SPEED10, PU=40kOhm"
io8p10_wsudq_i2cin_ls_ft  "SPEED10"
io8p11_wsudq_i2cin_ls_ft_pd  "SPEED11, PD=40kOhm"
io8p11_wsudq_i2cin_ls_ft_pu  "SPEED11, PU=40kOhm"
io8p11_wsudq_i2cin_ls_ft  "SPEED11"
[Model Selector] io8p_wsudq_lcd4_ls_ft
io8p00_wsudq_lcd4_ls_ft_pd_lv  "SPEED00 1P8V, PD=40kOhm"
io8p00_wsudq_lcd4_ls_ft_pu_lv  "SPEED00 1P8V, PU=40kOhm"
io8p00_wsudq_lcd4_ls_ft_lv  "SPEED00 1P8V"
io8p01_wsudq_lcd4_ls_ft_pd_lv  "SPEED01 1P8V, PD=40kOhm"
io8p01_wsudq_lcd4_ls_ft_pu_lv  "SPEED01 1P8V, PU=40kOhm"
io8p01_wsudq_lcd4_ls_ft_lv  "SPEED01 1P8V"
io8p10_wsudq_lcd4_ls_ft_pd_lv  "SPEED10 1P8V, PD=40kOhm"
io8p10_wsudq_lcd4_ls_ft_pu_lv  "SPEED10 1P8V, PU=40kOhm"
io8p10_wsudq_lcd4_ls_ft_lv  "SPEED10 1P8V"
io8p11_wsudq_lcd4_ls_ft_pd_lv  "SPEED11 1P8V, PD=40kOhm"
io8p11_wsudq_lcd4_ls_ft_pu_lv  "SPEED11 1P8V, PU=40kOhm"
io8p11_wsudq_lcd4_ls_ft_lv  "SPEED11 1P8V"
io8p00_wsudq_lcd4_ls_ft_pd  "SPEED00, PD=40kOhm"
io8p00_wsudq_lcd4_ls_ft_pu  "SPEED00, PU=40kOhm"
io8p00_wsudq_lcd4_ls_ft  "SPEED00"
io8p01_wsudq_lcd4_ls_ft_pd  "SPEED01, PD=40kOhm"
io8p01_wsudq_lcd4_ls_ft_pu  "SPEED01, PU=40kOhm"
io8p01_wsudq_lcd4_ls_ft  "SPEED01"
io8p10_wsudq_lcd4_ls_ft_pd  "SPEED10, PD=40kOhm"
io8p10_wsudq_lcd4_ls_ft_pu  "SPEED10, PU=40kOhm"
io8p10_wsudq_lcd4_ls_ft  "SPEED10"
io8p11_wsudq_lcd4_ls_ft_pd  "SPEED11, PD=40kOhm"
io8p11_wsudq_lcd4_ls_ft_pu  "SPEED11, PU=40kOhm"
io8p11_wsudq_lcd4_ls_ft  "SPEED11"
[Model Selector] io8p_wsudq_ls_ft_v33
io8p00_wsudq_ls_ft_v33_pd_lv  "SPEED00 1P8V, PD=40kOhm"
io8p00_wsudq_ls_ft_v33_pu_lv  "SPEED00 1P8V, PU=40kOhm"
io8p00_wsudq_ls_ft_v33_lv  "SPEED00 1P8V"
io8p01_wsudq_ls_ft_v33_pd_lv  "SPEED01 1P8V, PD=40kOhm"
io8p01_wsudq_ls_ft_v33_pu_lv  "SPEED01 1P8V, PU=40kOhm"
io8p01_wsudq_ls_ft_v33_lv  "SPEED01 1P8V"
io8p10_wsudq_ls_ft_v33_pd_lv  "SPEED10 1P8V, PD=40kOhm"
io8p10_wsudq_ls_ft_v33_pu_lv  "SPEED10 1P8V, PU=40kOhm"
io8p10_wsudq_ls_ft_v33_lv  "SPEED10 1P8V"
io8p11_wsudq_ls_ft_v33_pd_lv  "SPEED11 1P8V, PD=40kOhm"
io8p11_wsudq_ls_ft_v33_pu_lv  "SPEED11 1P8V, PU=40kOhm"
io8p11_wsudq_ls_ft_v33_lv  "SPEED11 1P8V"
io8p00_wsudq_ls_ft_v33_pd  "SPEED00, PD=40kOhm"
io8p00_wsudq_ls_ft_v33_pu  "SPEED00, PU=40kOhm"
io8p00_wsudq_ls_ft_v33  "SPEED00"
io8p01_wsudq_ls_ft_v33_pd  "SPEED01, PD=40kOhm"
io8p01_wsudq_ls_ft_v33_pu  "SPEED01, PU=40kOhm"
io8p01_wsudq_ls_ft_v33  "SPEED01"
io8p10_wsudq_ls_ft_v33_pd  "SPEED10, PD=40kOhm"
io8p10_wsudq_ls_ft_v33_pu  "SPEED10, PU=40kOhm"
io8p10_wsudq_ls_ft_v33  "SPEED10"
io8p11_wsudq_ls_ft_v33_pd  "SPEED11, PD=40kOhm"
io8p11_wsudq_ls_ft_v33_pu  "SPEED11, PU=40kOhm"
io8p11_wsudq_ls_ft_v33  "SPEED11"
[Model Selector] ioreset_tc_v33_esdft
ioreset_tc_v33_esdft_pu_lv  "IORESET 1P65V + PU=40kOhm"
ioreset_tc_v33_esdft_nopu_lv  "IORESET 1P65V"
ioreset_tc_v33_esdft_pu  "IORESET + PU=40kOhm"
ioreset_tc_v33_esdft_nopu  "IORESET"
[Model Selector] vpp_test_hv
vpp_test_hv_2p4  "Input Buffer 1P65V"
vpp_test_hv_3p3  "Input Buffer"
[Model Selector] io8usb_ls_ft
io8usb_ls_ft_dpdn_pu  "HS USB DP/DN IO + PU=1.2kOhm"
io8usb_ls_ft_dpdn  "HS USB DP/DN IO"
io8p00_ls_ft_pd_lv  "SPEED00 1P8V, PD=40kOhm"
io8p00_ls_ft_pu_lv  "SPEED00 1P8V, PU=40kOhm"
io8p00_ls_ft_lv  "SPEED00 1P8V"
io8p01_ls_ft_pd_lv  "SPEED01 1P8V, PD=40kOhm"
io8p01_ls_ft_pu_lv  "SPEED01 1P8V, PU=40kOhm"
io8p01_ls_ft_lv  "SPEED01 1P8V"
io8p10_ls_ft_pd_lv  "SPEED10 1P8V, PD=40kOhm"
io8p10_ls_ft_pu_lv  "SPEED10 1P8V, PU=40kOhm"
io8p10_ls_ft_lv  "SPEED10 1P8V"
io8p11_ls_ft_pd_lv  "SPEED11 1P8V, PD=40kOhm"
io8p11_ls_ft_pu_lv  "SPEED11 1P8V, PU=40kOhm"
io8p11_ls_ft_lv  "SPEED11 1P8V"
io8p00_ls_ft_pd  "SPEED00, PD=40kOhm"
io8p00_ls_ft_pu  "SPEED00, PU=40kOhm"
io8p00_ls_ft  "SPEED00"
io8p01_ls_ft_pd  "SPEED01, PD=40kOhm"
io8p01_ls_ft_pu  "SPEED01, PU=40kOhm"
io8p01_ls_ft  "SPEED01"
io8p10_ls_ft_pd  "SPEED10, PD=40kOhm"
io8p10_ls_ft_pu  "SPEED10, PU=40kOhm"
io8p10_ls_ft  "SPEED10"
io8p11_ls_ft_pd  "SPEED11, PD=40kOhm"
io8p11_ls_ft_pu  "SPEED11, PU=40kOhm"
io8p11_ls_ft  "SPEED11"
[Model Selector] io8p_sudq_lcd4_i2cin_ls_ft
io8p00_sudq_lcd4_i2cin_ls_ft_pd_lv  "SPEED00 1P8V, PD=40kOhm"
io8p00_sudq_lcd4_i2cin_ls_ft_pu_lv  "SPEED00 1P8V, PU=40kOhm"
io8p00_sudq_lcd4_i2cin_ls_ft_lv  "SPEED00 1P8V"
io8p01_sudq_lcd4_i2cin_ls_ft_pd_lv  "SPEED01 1P8V, PD=40kOhm"
io8p01_sudq_lcd4_i2cin_ls_ft_pu_lv  "SPEED01 1P8V, PU=40kOhm"
io8p01_sudq_lcd4_i2cin_ls_ft_lv  "SPEED01 1P8V"
io8p10_sudq_lcd4_i2cin_ls_ft_pd_lv  "SPEED10 1P8V, PD=40kOhm"
io8p10_sudq_lcd4_i2cin_ls_ft_pu_lv  "SPEED10 1P8V, PU=40kOhm"
io8p10_sudq_lcd4_i2cin_ls_ft_lv  "SPEED10 1P8V"
io8p11_sudq_lcd4_i2cin_ls_ft_pd_lv  "SPEED11 1P8V, PD=40kOhm"
io8p11_sudq_lcd4_i2cin_ls_ft_pu_lv  "SPEED11 1P8V, PU=40kOhm"
io8p11_sudq_lcd4_i2cin_ls_ft_lv  "SPEED11 1P8V"
io8p00_sudq_lcd4_i2cin_ls_ft_pd  "SPEED00, PD=40kOhm"
io8p00_sudq_lcd4_i2cin_ls_ft_pu  "SPEED00, PU=40kOhm"
io8p00_sudq_lcd4_i2cin_ls_ft  "SPEED00"
io8p01_sudq_lcd4_i2cin_ls_ft_pd  "SPEED01, PD=40kOhm"
io8p01_sudq_lcd4_i2cin_ls_ft_pu  "SPEED01, PU=40kOhm"
io8p01_sudq_lcd4_i2cin_ls_ft  "SPEED01"
io8p10_sudq_lcd4_i2cin_ls_ft_pd  "SPEED10, PD=40kOhm"
io8p10_sudq_lcd4_i2cin_ls_ft_pu  "SPEED10, PU=40kOhm"
io8p10_sudq_lcd4_i2cin_ls_ft  "SPEED10"
io8p11_sudq_lcd4_i2cin_ls_ft_pd  "SPEED11, PD=40kOhm"
io8p11_sudq_lcd4_i2cin_ls_ft_pu  "SPEED11, PU=40kOhm"
io8p11_sudq_lcd4_i2cin_ls_ft  "SPEED11"
| Models and submodels in the file (176): io8p00_sudq_ls_ft_pd_lv (I/O), io8p00_sudq_ls_ft_pu_lv (I/O), io8p00_sudq_ls_ft_lv (I/O), io8p01_sudq_ls_ft_pd_lv (I/O), io8p01_sudq_ls_ft_pu_lv (I/O), io8p01_sudq_ls_ft_lv (I/O), io8p10_sudq_ls_ft_pd_lv (I/O), io8p10_sudq_ls_ft_pu_lv (I/O), io8p10_sudq_ls_ft_lv (I/O), io8p11_sudq_ls_ft_pd_lv (I/O), io8p11_sudq_ls_ft_pu_lv (I/O), io8p11_sudq_ls_ft_lv (I/O), io8p00_sudq_ls_ft_pd (I/O), io8p00_sudq_ls_ft_pu (I/O), io8p00_sudq_ls_ft (I/O), io8p01_sudq_ls_ft_pd (I/O), io8p01_sudq_ls_ft_pu (I/O), io8p01_sudq_ls_ft (I/O), io8p10_sudq_ls_ft_pd (I/O), io8p10_sudq_ls_ft_pu (I/O), io8p10_sudq_ls_ft (I/O), io8p11_sudq_ls_ft_pd (I/O), io8p11_sudq_ls_ft_pu (I/O), io8p11_sudq_ls_ft (I/O), io8p00_sudq_ls_tc_esdft_pd_lv (I/O), io8p00_sudq_ls_tc_esdft_pu_lv (I/O), io8p00_sudq_ls_tc_esdft_lv (I/O), io8p01_sudq_ls_tc_esdft_pd_lv (I/O), io8p01_sudq_ls_tc_esdft_pu_lv (I/O), io8p01_sudq_ls_tc_esdft_lv (I/O), io8p10_sudq_ls_tc_esdft_pd_lv (I/O), io8p10_sudq_ls_tc_esdft_pu_lv (I/O), io8p10_sudq_ls_tc_esdft_lv (I/O), io8p11_sudq_ls_tc_esdft_pd_lv (I/O), io8p11_sudq_ls_tc_esdft_pu_lv (I/O), io8p11_sudq_ls_tc_esdft_lv (I/O), io8p00_sudq_ls_tc_esdft_pd (I/O), io8p00_sudq_ls_tc_esdft_pu (I/O), io8p00_sudq_ls_tc_esdft (I/O), io8p01_sudq_ls_tc_esdft_pd (I/O), io8p01_sudq_ls_tc_esdft_pu (I/O), io8p01_sudq_ls_tc_esdft (I/O), io8p10_sudq_ls_tc_esdft_pd (I/O), io8p10_sudq_ls_tc_esdft_pu (I/O), io8p10_sudq_ls_tc_esdft (I/O), io8p11_sudq_ls_tc_esdft_pd (I/O), io8p11_sudq_ls_tc_esdft_pu (I/O), io8p11_sudq_ls_tc_esdft (I/O), io8p00_wsudq_i2cin_ls_ft_pd_lv (I/O), io8p00_wsudq_i2cin_ls_ft_pu_lv (I/O), io8p00_wsudq_i2cin_ls_ft_lv (I/O), io8p01_wsudq_i2cin_ls_ft_pd_lv (I/O), io8p01_wsudq_i2cin_ls_ft_pu_lv (I/O), io8p01_wsudq_i2cin_ls_ft_lv (I/O), io8p10_wsudq_i2cin_ls_ft_pd_lv (I/O), io8p10_wsudq_i2cin_ls_ft_pu_lv (I/O), io8p10_wsudq_i2cin_ls_ft_lv (I/O), io8p11_wsudq_i2cin_ls_ft_pd_lv (I/O), io8p11_wsudq_i2cin_ls_ft_pu_lv (I/O), io8p11_wsudq_i2cin_ls_ft_lv (I/O), io8p00_wsudq_i2cin_ls_ft_pd (I/O), io8p00_wsudq_i2cin_ls_ft_pu (I/O), io8p00_wsudq_i2cin_ls_ft (I/O), io8p01_wsudq_i2cin_ls_ft_pd (I/O), io8p01_wsudq_i2cin_ls_ft_pu (I/O), io8p01_wsudq_i2cin_ls_ft (I/O), io8p10_wsudq_i2cin_ls_ft_pd (I/O), io8p10_wsudq_i2cin_ls_ft_pu (I/O), io8p10_wsudq_i2cin_ls_ft (I/O), io8p11_wsudq_i2cin_ls_ft_pd (I/O), io8p11_wsudq_i2cin_ls_ft_pu (I/O), io8p11_wsudq_i2cin_ls_ft (I/O), io8p00_wsudq_lcd4_ls_ft_pd_lv (I/O), io8p00_wsudq_lcd4_ls_ft_pu_lv (I/O), io8p00_wsudq_lcd4_ls_ft_lv (I/O), io8p01_wsudq_lcd4_ls_ft_pd_lv (I/O), io8p01_wsudq_lcd4_ls_ft_pu_lv (I/O), io8p01_wsudq_lcd4_ls_ft_lv (I/O), io8p10_wsudq_lcd4_ls_ft_pd_lv (I/O), io8p10_wsudq_lcd4_ls_ft_pu_lv (I/O)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
